* Extracted by KLayout with GF180MCU LVS runset on : 02/11/2026 03:53

* cell InputBuffer
.SUBCKT InputBuffer
* device instance $1 r0 *1 -14.25,13.32 pfet_03v3
M$1 \$6 \$7 \$5 \$6 pfet_03v3 L=0.28U W=10U AS=5.3P AD=2.6P PS=21.06U PD=10.52U
* device instance $2 r0 *1 -13.45,13.32 pfet_03v3
M$2 \$5 \$7 \$6 \$6 pfet_03v3 L=0.28U W=10U AS=2.6P AD=2.6P PS=10.52U PD=10.52U
* device instance $3 r0 *1 -12.65,13.32 pfet_03v3
M$3 \$6 \$7 \$5 \$6 pfet_03v3 L=0.28U W=10U AS=2.6P AD=2.6P PS=10.52U PD=10.52U
* device instance $4 r0 *1 -11.85,13.32 pfet_03v3
M$4 \$5 \$7 \$6 \$6 pfet_03v3 L=0.28U W=10U AS=2.6P AD=2.6P PS=10.52U PD=10.52U
* device instance $5 r0 *1 -11.05,13.32 pfet_03v3
M$5 \$6 \$7 \$5 \$6 pfet_03v3 L=0.28U W=10U AS=2.6P AD=5.7P PS=10.52U PD=21.14U
* device instance $6 r0 *1 -17.88,14.51 pfet_03v3
M$6 \$9 \$11 \$6 \$6 pfet_03v3 L=0.3U W=0.6U AS=0.54P AD=0.48P PS=3U PD=2.8U
* device instance $7 r0 *1 -19.08,11.86 pfet_03v3
M$7 \$9 \$10 \$7 \$6 pfet_03v3 L=0.3U W=0.6U AS=0.474P AD=0.27P PS=2.78U PD=1.5U
* device instance $8 r0 *1 -17.88,11.86 pfet_03v3
M$8 \$8 \$5 \$9 \$6 pfet_03v3 L=0.3U W=0.6U AS=0.27P AD=0.486P PS=1.5U PD=2.82U
* device instance $9 r0 *1 -19.09,8.31 nfet_03v3
M$9 SUB \$8 \$7 SUB nfet_03v3 L=0.3U W=0.6U AS=0.468P AD=0.273P PS=2.76U
+ PD=1.51U
* device instance $10 r0 *1 -17.88,8.31 nfet_03v3
M$10 \$8 \$8 SUB SUB nfet_03v3 L=0.3U W=0.6U AS=0.273P AD=0.486P PS=1.51U
+ PD=2.82U
* device instance $11 r0 *1 -14.25,1.96 nfet_03v3
M$11 \$3 \$1 \$5 SUB nfet_03v3 L=0.28U W=10U AS=6P AD=2.6P PS=21.2U PD=10.52U
* device instance $12 r0 *1 -13.45,1.96 nfet_03v3
M$12 \$5 \$1 \$3 SUB nfet_03v3 L=0.28U W=10U AS=2.6P AD=2.6P PS=10.52U PD=10.52U
* device instance $13 r0 *1 -12.65,1.96 nfet_03v3
M$13 \$3 \$1 \$5 SUB nfet_03v3 L=0.28U W=10U AS=2.6P AD=2.6P PS=10.52U PD=10.52U
* device instance $14 r0 *1 -11.85,1.96 nfet_03v3
M$14 \$5 \$1 \$3 SUB nfet_03v3 L=0.28U W=10U AS=2.6P AD=2.6P PS=10.52U PD=10.52U
* device instance $15 r0 *1 -11.05,1.96 nfet_03v3
M$15 \$3 \$1 \$5 SUB nfet_03v3 L=0.28U W=10U AS=2.6P AD=5.5P PS=10.52U PD=21.1U
* device instance $16 m135 *1 -2.78,8.71 ppolyf_s
R$16 SUB \$3 SUB 65.7 ppolyf_s L=36U W=4U
.ENDS InputBuffer
