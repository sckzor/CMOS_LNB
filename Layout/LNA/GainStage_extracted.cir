* Extracted by KLayout with GF180MCU LVS runset on : 02/11/2026 03:37

* cell GainStage
.SUBCKT GainStage
* device instance $1 r0 *1 -3.91,14.32 pfet_03v3
M$1 \$12 \$13 \$10 \$12 pfet_03v3 L=0.28U W=10U AS=5.3P AD=2.6P PS=21.06U
+ PD=10.52U
* device instance $2 r0 *1 -3.11,14.32 pfet_03v3
M$2 \$10 \$13 \$12 \$12 pfet_03v3 L=0.28U W=10U AS=2.6P AD=2.6P PS=10.52U
+ PD=10.52U
* device instance $3 r0 *1 -2.31,14.32 pfet_03v3
M$3 \$12 \$13 \$10 \$12 pfet_03v3 L=0.28U W=10U AS=2.6P AD=2.6P PS=10.52U
+ PD=10.52U
* device instance $4 r0 *1 -1.51,14.32 pfet_03v3
M$4 \$10 \$13 \$12 \$12 pfet_03v3 L=0.28U W=10U AS=2.6P AD=2.6P PS=10.52U
+ PD=10.52U
* device instance $5 r0 *1 -0.71,14.32 pfet_03v3
M$5 \$12 \$13 \$10 \$12 pfet_03v3 L=0.28U W=10U AS=2.6P AD=5.7P PS=10.52U
+ PD=21.14U
* device instance $6 r0 *1 0.66,6.63 pfet_03v3
M$6 \$12 \$11 \$8 \$12 pfet_03v3 L=0.3U W=0.6U AS=0.48P AD=0.54P PS=2.8U PD=3U
* device instance $7 r0 *1 0.74,3.98 pfet_03v3
M$7 \$8 \$5 \$7 \$12 pfet_03v3 L=0.3U W=0.6U AS=0.48P AD=0.267P PS=2.8U PD=1.49U
* device instance $8 r0 *1 1.93,3.98 pfet_03v3
M$8 \$13 \$9 \$8 \$12 pfet_03v3 L=0.3U W=0.6U AS=0.267P AD=0.486P PS=1.49U
+ PD=2.82U
* device instance $9 r0 *1 0.74,1.33 nfet_03v3
M$9 SUB \$7 \$7 SUB nfet_03v3 L=0.3U W=0.6U AS=0.48P AD=0.273P PS=2.8U PD=1.51U
* device instance $10 r0 *1 1.95,1.33 nfet_03v3
M$10 \$13 \$7 SUB SUB nfet_03v3 L=0.3U W=0.6U AS=0.273P AD=0.474P PS=1.51U
+ PD=2.78U
* device instance $11 r0 *1 -3.91,-5.67 nfet_03v3
M$11 \$4 \$2 \$5 SUB nfet_03v3 L=0.28U W=10U AS=6P AD=2.6P PS=21.2U PD=10.52U
* device instance $12 r0 *1 -3.11,-5.67 nfet_03v3
M$12 \$5 \$2 \$4 SUB nfet_03v3 L=0.28U W=10U AS=2.6P AD=2.6P PS=10.52U PD=10.52U
* device instance $13 r0 *1 -2.31,-5.67 nfet_03v3
M$13 \$4 \$2 \$5 SUB nfet_03v3 L=0.28U W=10U AS=2.6P AD=2.6P PS=10.52U PD=10.52U
* device instance $14 r0 *1 -1.51,-5.67 nfet_03v3
M$14 \$5 \$2 \$4 SUB nfet_03v3 L=0.28U W=10U AS=2.6P AD=2.6P PS=10.52U PD=10.52U
* device instance $15 r0 *1 -0.71,-5.67 nfet_03v3
M$15 \$4 \$2 \$5 SUB nfet_03v3 L=0.28U W=10U AS=2.6P AD=2.6P PS=10.52U PD=10.52U
* device instance $16 r0 *1 0.09,-5.67 nfet_03v3
M$16 SUB \$3 \$4 SUB nfet_03v3 L=0.28U W=10U AS=2.6P AD=2.6P PS=10.52U PD=10.52U
* device instance $17 r0 *1 0.89,-5.67 nfet_03v3
M$17 \$4 \$3 SUB SUB nfet_03v3 L=0.28U W=10U AS=2.6P AD=2.6P PS=10.52U PD=10.52U
* device instance $18 r0 *1 1.69,-5.67 nfet_03v3
M$18 SUB \$3 \$4 SUB nfet_03v3 L=0.28U W=10U AS=2.6P AD=2.6P PS=10.52U PD=10.52U
* device instance $19 r0 *1 2.49,-5.67 nfet_03v3
M$19 \$4 \$3 SUB SUB nfet_03v3 L=0.28U W=10U AS=2.6P AD=2.6P PS=10.52U PD=10.52U
* device instance $20 r0 *1 3.29,-5.67 nfet_03v3
M$20 SUB \$3 \$4 SUB nfet_03v3 L=0.28U W=10U AS=2.6P AD=7.3P PS=10.52U PD=21.46U
* device instance $21 r0 *1 -2.71,4.18 ppolyf_s
R$21 \$5 \$10 SUB 18.25 ppolyf_s L=5U W=2U
.ENDS GainStage
