* NGSPICE file created from TOP.ext - technology: gf180mcuD

.subckt TOP Input GainStage1 GainStage2 InputBuffer Output VDD GND Com TBias CBias
+ CGBias
X0 InputBuffer a_5048_1590# VDD VDD pfet_03v3 ad=2.6p pd=10.52u as=2.6p ps=10.52u w=10u l=0.28u
X1 GND a_150_194# a_150_194# GND nfet_03v3 ad=0.273p pd=1.51u as=0.48p ps=2.8u w=0.6u l=0.3u
X2 a_2346_n2146# InputBuffer GND GND nfet_03v3 ad=2.6p pd=10.52u as=2.6p ps=10.52u w=10u l=0.28u
X3 Input CGBias InputBuffer GND nfet_03v3 ad=2.6p pd=10.52u as=2.6p ps=10.52u w=10u l=0.28u
X4 a_2264_4164# a_3058_194# GND GND nfet_03v3 ad=0.474p pd=2.78u as=0.273p ps=1.51u w=0.6u l=0.3u
X5 a_2346_n2146# CBias GainStage1 GND nfet_03v3 ad=2.6p pd=10.52u as=6p ps=21.2u w=10u l=0.28u
X6 GND InputBuffer a_2346_n2146# GND nfet_03v3 ad=13.2p pd=22.64u as=2.6p ps=10.52u w=10u l=0.28u
X7 a_n562_n2146# CBias GainStage2 GND nfet_03v3 ad=2.6p pd=10.52u as=2.6p ps=10.52u w=10u l=0.28u
X8 GainStage1 CBias a_2346_n2146# GND nfet_03v3 ad=2.6p pd=10.52u as=2.6p ps=10.52u w=10u l=0.28u
X9 InputBuffer CGBias Input GND nfet_03v3 ad=2.6p pd=10.52u as=2.6p ps=10.52u w=10u l=0.28u
X10 a_5182_1808# InputBuffer a_5266_2300# VDD pfet_03v3 ad=0.486p pd=2.82u as=0.27p ps=1.5u w=0.6u l=0.3u
X11 VDD TBias a_3042_1254# VDD pfet_03v3 ad=0.9p pd=4.2u as=0.48p ps=2.8u w=0.6u l=0.3u
X12 GND InputBuffer a_2346_n2146# GND nfet_03v3 ad=2.6p pd=10.52u as=2.6p ps=10.52u w=10u l=0.28u
X13 VDD a_n644_4164# a_n724_1852# VDD pfet_03v3 ad=2.6p pd=10.52u as=2.6p ps=10.52u w=10u l=0.28u
X14 a_2346_n2146# InputBuffer GND GND nfet_03v3 ad=2.6p pd=10.52u as=2.6p ps=10.52u w=10u l=0.28u
X15 a_n724_1852# a_n644_4164# VDD VDD pfet_03v3 ad=2.6p pd=10.52u as=2.6p ps=10.52u w=10u l=0.28u
X16 a_2184_1852# a_2264_4164# VDD VDD pfet_03v3 ad=2.6p pd=10.52u as=2.6p ps=10.52u w=10u l=0.28u
X17 VDD a_5048_1590# InputBuffer VDD pfet_03v3 ad=2.6p pd=10.52u as=2.6p ps=10.52u w=10u l=0.28u
X18 a_134_1254# GainStage2 a_150_194# VDD pfet_03v3 ad=0.267p pd=1.49u as=0.48p ps=2.8u w=0.6u l=0.3u
X19 InputBuffer a_5048_1590# VDD VDD pfet_03v3 ad=2.6p pd=10.52u as=2.6p ps=10.52u w=10u l=0.28u
X20 GND a_3058_194# a_3058_194# GND nfet_03v3 ad=0.273p pd=1.51u as=0.48p ps=2.8u w=0.6u l=0.3u
X21 Input CGBias InputBuffer GND nfet_03v3 ad=2.6p pd=10.52u as=6p ps=21.2u w=10u l=0.28u
X22 a_n644_4164# Com a_134_1254# VDD pfet_03v3 ad=0.486p pd=2.82u as=0.267p ps=1.49u w=0.6u l=0.3u
X23 Input CGBias InputBuffer GND nfet_03v3 ad=5.5p pd=21.1u as=2.6p ps=10.52u w=10u l=0.28u
X24 a_2184_1852# GainStage1 GND ppolyf_s r_width=2u r_length=5u
X25 GND GainStage1 a_n562_n2146# GND nfet_03v3 ad=2.6p pd=10.52u as=2.6p ps=10.52u w=10u l=0.28u
X26 a_n724_1852# GainStage2 GND ppolyf_s r_width=2u r_length=5u
X27 VDD GainStage2 Output GND npn_10p00x10p00
X28 VDD a_2264_4164# a_2184_1852# VDD pfet_03v3 ad=2.6p pd=10.52u as=5.3p ps=21.06u w=10u l=0.28u
X29 GND Input GND ppolyf_s r_width=4u r_length=36u
X30 VDD TBias a_134_1254# VDD pfet_03v3 ad=0.9p pd=4.2u as=0.48p ps=2.8u w=0.6u l=0.3u
X31 GainStage2 CBias a_n562_n2146# GND nfet_03v3 ad=2.6p pd=10.52u as=2.6p ps=10.52u w=10u l=0.28u
X32 VDD a_n644_4164# a_n724_1852# VDD pfet_03v3 ad=2.6p pd=10.52u as=5.3p ps=21.06u w=10u l=0.28u
X33 VDD a_5048_1590# InputBuffer VDD pfet_03v3 ad=2.6p pd=10.52u as=5.3p ps=21.06u w=10u l=0.28u
X34 Output GND GND ppolyf_u_1k r_width=4u r_length=4u
X35 a_n562_n2146# CBias GainStage2 GND nfet_03v3 ad=2.6p pd=10.52u as=6p ps=21.2u w=10u l=0.28u
X36 a_2346_n2146# CBias GainStage1 GND nfet_03v3 ad=2.6p pd=10.52u as=2.6p ps=10.52u w=10u l=0.28u
X37 VDD a_2264_4164# a_2184_1852# VDD pfet_03v3 ad=12.9p pd=22.58u as=2.6p ps=10.52u w=10u l=0.28u
X38 a_5266_2300# TBias VDD VDD pfet_03v3 ad=0.48p pd=2.8u as=0.9p ps=4.2u w=0.6u l=0.3u
X39 a_3042_1254# GainStage1 a_3058_194# VDD pfet_03v3 ad=0.267p pd=1.49u as=0.48p ps=2.8u w=0.6u l=0.3u
X40 a_2264_4164# Com a_3042_1254# VDD pfet_03v3 ad=0.486p pd=2.82u as=0.267p ps=1.49u w=0.6u l=0.3u
X41 a_n562_n2146# GainStage1 GND GND nfet_03v3 ad=2.6p pd=10.52u as=2.6p ps=10.52u w=10u l=0.28u
X42 VDD a_5048_1590# InputBuffer VDD pfet_03v3 ad=12.9p pd=22.58u as=2.6p ps=10.52u w=10u l=0.28u
X43 a_n644_4164# a_150_194# GND GND nfet_03v3 ad=0.474p pd=2.78u as=0.273p ps=1.51u w=0.6u l=0.3u
X44 GND GainStage1 a_n562_n2146# GND nfet_03v3 ad=13.2p pd=22.64u as=2.6p ps=10.52u w=10u l=0.28u
X45 InputBuffer CGBias Input GND nfet_03v3 ad=2.6p pd=10.52u as=2.6p ps=10.52u w=10u l=0.28u
X46 a_5182_1808# a_5182_1808# GND GND nfet_03v3 ad=0.486p pd=2.82u as=0.273p ps=1.51u w=0.6u l=0.3u
X47 a_5266_2300# Com a_5048_1590# VDD pfet_03v3 ad=0.27p pd=1.5u as=0.474p ps=2.78u w=0.6u l=0.3u
X48 GND InputBuffer a_2346_n2146# GND nfet_03v3 ad=2.6p pd=10.52u as=2.6p ps=10.52u w=10u l=0.28u
X49 a_n562_n2146# CBias GainStage2 GND nfet_03v3 ad=2.6p pd=10.52u as=2.6p ps=10.52u w=10u l=0.28u
X50 VDD a_n644_4164# a_n724_1852# VDD pfet_03v3 ad=12.9p pd=22.58u as=2.6p ps=10.52u w=10u l=0.28u
X51 GainStage2 CBias a_n562_n2146# GND nfet_03v3 ad=2.6p pd=10.52u as=2.6p ps=10.52u w=10u l=0.28u
X52 GainStage1 CBias a_2346_n2146# GND nfet_03v3 ad=2.6p pd=10.52u as=2.6p ps=10.52u w=10u l=0.28u
X53 a_2346_n2146# CBias GainStage1 GND nfet_03v3 ad=2.6p pd=10.52u as=2.6p ps=10.52u w=10u l=0.28u
X54 GND GainStage1 a_n562_n2146# GND nfet_03v3 ad=2.6p pd=10.52u as=2.6p ps=10.52u w=10u l=0.28u
X55 a_n724_1852# a_n644_4164# VDD VDD pfet_03v3 ad=2.6p pd=10.52u as=2.6p ps=10.52u w=10u l=0.28u
X56 a_2184_1852# a_2264_4164# VDD VDD pfet_03v3 ad=2.6p pd=10.52u as=2.6p ps=10.52u w=10u l=0.28u
X57 GND a_5182_1808# a_5048_1590# GND nfet_03v3 ad=0.273p pd=1.51u as=0.468p ps=2.76u w=0.6u l=0.3u
X58 a_n562_n2146# GainStage1 GND GND nfet_03v3 ad=2.6p pd=10.52u as=2.6p ps=10.52u w=10u l=0.28u
X59 VDD a_2264_4164# a_2184_1852# VDD pfet_03v3 ad=2.6p pd=10.52u as=2.6p ps=10.52u w=10u l=0.28u
.ends
